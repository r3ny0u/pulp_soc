{ 
    name: "custom_axi_ip",
    clock_primary: "clk_i",
    reset_primary: "rst_ni",
    bus_interfaces: [
        {
            protocol: "reg_iface", 
            direction: "device"
        }
    ],

    regwidth: "32",
    registers: [
        { 
            multireg: {
                name: "REG0",
                desc: "First custom register",
                count: "1",
                cname: "REG0",
                swaccess: "rw",     // Software access: read/write
                hwaccess: "hrw",    // Hardware access: read/write
                fields: [
                    { bits: "31:0" }  // Register field definition
                ]
            }
        },
        { 
            multireg: {
                name: "REG1",
                desc: "Second custom register",
                count: "1",
                cname: "REG1",
                swaccess: "rw",
                hwaccess: "hrw",
                fields: [
                    { bits: "31:0" }
                ]
            }
        },
        { 
            multireg: {
                name: "REG2",
                desc: "Third custom register",
                count: "1",
                cname: "REG2",
                swaccess: "rw",
                hwaccess: "hrw",
                fields: [
                    { bits: "31:0" }
                ]
            }
        }
    ]
}
