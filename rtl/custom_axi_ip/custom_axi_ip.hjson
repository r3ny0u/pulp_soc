{ 
    name: "custom_axi_ip",
    clock_primary: "clk_i",
    reset_primary: "rst_ni",
    bus_interfaces: [
        {
            protocol: "reg_iface", 
            direction: "device"
        }
    ],

    regwidth: "32",
    registers: [
        { 
            multireg: {
                name: "REGs",
                desc: "Custom register",
                count: "3",
                cname: "REGs",
                swaccess: "rw",     // Software access: read/write
                hwaccess: "hrw",    // Hardware access: read/write
                hwqe: "true",
                fields: [
                    { bits: "31:0" }  // Register field definition
                ]
            },
        },
    ]
}
